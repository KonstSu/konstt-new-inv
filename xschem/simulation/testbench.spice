** sch_path: /home/ttuser/asic/konstt-new-inv/xschem/testbench.sch
**.subckt testbench in
*.ipin in
x1 VDD VSS out in konstt-new-inv
V1 VDD GND 1.8
V2 VSS GND 0
R1 out_pin out 1k m=1
C1 out_pin GND 1p m=1
**** begin user architecture code

** opencircuitdesign pdks install
.lib /home/ttuser/pdk/sky130A/libs.tech/ngspice/sky130.lib.spice tt

* ngspice commands
vin in 0 pulse 0.8 1 500n 100n 100n 5u 10u
.control
tran 10n 20u
write testbench.raw
.endc

**** end user architecture code
**.ends

* expanding   symbol:  konstt-new-inv.sym # of pins=4
** sym_path: /home/ttuser/asic/konstt-new-inv/xschem/konstt-new-inv.sym
** sch_path: /home/ttuser/asic/konstt-new-inv/xschem/konstt-new-inv.sch
.subckt konstt-new-inv VDD VSS out0 in0
*.iopin VDD
*.iopin VSS
*.ipin in0
*.opin out0
XM1 inverted in0 VDD VDD sky130_fd_pr__pfet_01v8 L=0.15 W=1 nf=1 ad='int((nf+1)/2) * W/nf * 0.29' as='int((nf+2)/2) * W/nf * 0.29'
+ pd='2*int((nf+1)/2) * (W/nf + 0.29)' ps='2*int((nf+2)/2) * (W/nf + 0.29)' nrd='0.29 / W' nrs='0.29 / W' sa=0 sb=0 sd=0 mult=1 m=1
XM2 inverted in0 VSS VSS sky130_fd_pr__nfet_01v8 L=0.15 W=1 nf=1 ad='int((nf+1)/2) * W/nf * 0.29' as='int((nf+2)/2) * W/nf * 0.29'
+ pd='2*int((nf+1)/2) * (W/nf + 0.29)' ps='2*int((nf+2)/2) * (W/nf + 0.29)' nrd='0.29 / W' nrs='0.29 / W' sa=0 sb=0 sd=0 mult=1 m=1
XM3 out0 inverted VDD VDD sky130_fd_pr__pfet_01v8 L=0.15 W=20 nf=20 ad='int((nf+1)/2) * W/nf * 0.29' as='int((nf+2)/2) * W/nf * 0.29'
+ pd='2*int((nf+1)/2) * (W/nf + 0.29)' ps='2*int((nf+2)/2) * (W/nf + 0.29)' nrd='0.29 / W' nrs='0.29 / W' sa=0 sb=0 sd=0 mult=1 m=1
XM4 out0 inverted VSS VSS sky130_fd_pr__nfet_01v8 L=0.15 W=20 nf=20 ad='int((nf+1)/2) * W/nf * 0.29' as='int((nf+2)/2) * W/nf * 0.29'
+ pd='2*int((nf+1)/2) * (W/nf + 0.29)' ps='2*int((nf+2)/2) * (W/nf + 0.29)' nrd='0.29 / W' nrs='0.29 / W' sa=0 sb=0 sd=0 mult=1 m=1
.ends

.GLOBAL GND
.end
